* SPICE NETLIST
***************************************

.SUBCKT LDDP D G S B
.ENDS
***************************************
.SUBCKT LDDN D G S B
.ENDS
***************************************
.SUBCKT crtmom PLUS MINUS BULK
.ENDS
***************************************
.SUBCKT crtmom_2t PLUS MINUS
.ENDS
***************************************
.SUBCKT crtmom_rf PLUS MINUS BULK
.ENDS
***************************************
.SUBCKT crtmom_rf_rdk PLUS MINUS BULK
.ENDS
***************************************
.SUBCKT crtmom_mx PLUS1 MINUS1 PLUS2 MINUS2 BULK
.ENDS
***************************************
.SUBCKT fmom PLUS MINUS BULK
.ENDS
***************************************
.SUBCKT fmom_mx PLUS1 MINUS1 PLUS2 MINUS2 BULK
.ENDS
***************************************
.SUBCKT lincap PLUS MINUS
.ENDS
***************************************
.SUBCKT lincap_25 PLUS MINUS
.ENDS
***************************************
.SUBCKT lincap_rf PLUS MINUS BULK
.ENDS
***************************************
.SUBCKT lincap_rf_25 PLUS MINUS BULK
.ENDS
***************************************
.SUBCKT lowcpad_d15 APAD AVSS
.ENDS
***************************************
.SUBCKT lowcpad_d23 APAD AVSS
.ENDS
***************************************
.SUBCKT mimcap_sin PLUS MINUS
.ENDS
***************************************
.SUBCKT mimcap_sin_3t PLUS MINUS BULK
.ENDS
***************************************
.SUBCKT mimcap_um_sin_rf PLUS MINUS BULK
.ENDS
***************************************
.SUBCKT mimcap_woum_sin_rf PLUS MINUS BULK
.ENDS
***************************************
.SUBCKT moscap_rf PLUS MINUS BULK
.ENDS
***************************************
.SUBCKT moscap_rf18 PLUS MINUS BULK
.ENDS
***************************************
.SUBCKT moscap_rf18_nw PLUS MINUS BULK
.ENDS
***************************************
.SUBCKT moscap_rf25 PLUS MINUS BULK
.ENDS
***************************************
.SUBCKT moscap_rf25_nw PLUS MINUS BULK
.ENDS
***************************************
.SUBCKT moscap_rf33 PLUS MINUS BULK
.ENDS
***************************************
.SUBCKT moscap_rf33_nw PLUS MINUS BULK
.ENDS
***************************************
.SUBCKT moscap_rf_hvt PLUS MINUS BULK
.ENDS
***************************************
.SUBCKT moscap_rf_hvt_nw PLUS MINUS BULK
.ENDS
***************************************
.SUBCKT moscap_rf_nw PLUS MINUS BULK
.ENDS
***************************************
.SUBCKT moscap_rf_rdk PLUS MINUS BULK
.ENDS
***************************************
.SUBCKT ndio_hia_rf PLUS MINUS
.ENDS
***************************************
.SUBCKT nmos_rf D G S B
.ENDS
***************************************
.SUBCKT nmos_rf_18 D G S B
.ENDS
***************************************
.SUBCKT nmos_rf_18_6t D G S B NG PG
.ENDS
***************************************
.SUBCKT nmos_rf_18_nodnw D G S B
.ENDS
***************************************
.SUBCKT nmos_rf_25 D G S B
.ENDS
***************************************
.SUBCKT nmos_rf_25_6t D G S B NG PG
.ENDS
***************************************
.SUBCKT nmos_rf_25_nodnw D G S B
.ENDS
***************************************
.SUBCKT nmos_rf_25_nodnwod D G S B
.ENDS
***************************************
.SUBCKT nmos_rf_25_nodnwud D G S B
.ENDS
***************************************
.SUBCKT nmos_rf_25od D G S B
.ENDS
***************************************
.SUBCKT nmos_rf_25od33_6t D G S B NG PG
.ENDS
***************************************
.SUBCKT nmos_rf_25ud D G S B
.ENDS
***************************************
.SUBCKT nmos_rf_25ud18_6t D G S B NG PG
.ENDS
***************************************
.SUBCKT nmos_rf_33 D G S B
.ENDS
***************************************
.SUBCKT nmos_rf_33_6t D G S B NG PG
.ENDS
***************************************
.SUBCKT nmos_rf_33_nodnw D G S B
.ENDS
***************************************
.SUBCKT nmos_rf_6t D G S B NG PG
.ENDS
***************************************
.SUBCKT nmos_rf_cas_nw D GB S B GT
.ENDS
***************************************
.SUBCKT nmos_rf_cross_nw DP DM S B
.ENDS
***************************************
.SUBCKT nmos_rf_diff_nw DP GP S B DM GM
.ENDS
***************************************
.SUBCKT nmos_rf_hvt D G S B
.ENDS
***************************************
.SUBCKT nmos_rf_hvt_6t D G S B NG PG
.ENDS
***************************************
.SUBCKT nmos_rf_hvt_nodnw D G S B
.ENDS
***************************************
.SUBCKT nmos_rf_lvt D G S B
.ENDS
***************************************
.SUBCKT nmos_rf_lvt_6t D G S B NG PG
.ENDS
***************************************
.SUBCKT nmos_rf_lvt_nodnw D G S B
.ENDS
***************************************
.SUBCKT nmos_rf_mlvt D G S B
.ENDS
***************************************
.SUBCKT nmos_rf_mlvt_6t D G S B NG PG
.ENDS
***************************************
.SUBCKT nmos_rf_mlvt_nodnw D G S B
.ENDS
***************************************
.SUBCKT nmos_rf_na18 D G S B
.ENDS
***************************************
.SUBCKT nmos_rf_nodnw D G S B
.ENDS
***************************************
.SUBCKT nmos_rf_rdk D G S B
.ENDS
***************************************
.SUBCKT nmoscap PLUS MINUS
.ENDS
***************************************
.SUBCKT nmoscap_18 PLUS MINUS
.ENDS
***************************************
.SUBCKT nmoscap_25 PLUS MINUS
.ENDS
***************************************
.SUBCKT nmoscap_33 PLUS MINUS
.ENDS
***************************************
.SUBCKT nmoscap_lpg PLUS MINUS
.ENDS
***************************************
.SUBCKT pdio_hia_rf PLUS MINUS BULK
.ENDS
***************************************
.SUBCKT pmos_rf D G S B
.ENDS
***************************************
.SUBCKT pmos_rf_18 D G S B
.ENDS
***************************************
.SUBCKT pmos_rf_18_5t D G S B PG
.ENDS
***************************************
.SUBCKT pmos_rf_18_nw D G S B
.ENDS
***************************************
.SUBCKT pmos_rf_18_nw_5t D G S B PG
.ENDS
***************************************
.SUBCKT pmos_rf_25 D G S B
.ENDS
***************************************
.SUBCKT pmos_rf_25_5t D G S B PG
.ENDS
***************************************
.SUBCKT pmos_rf_25_nw D G S B
.ENDS
***************************************
.SUBCKT pmos_rf_25_nw_5t D G S B PG
.ENDS
***************************************
.SUBCKT pmos_rf_25_nwod D G S B
.ENDS
***************************************
.SUBCKT pmos_rf_25_nwud D G S B
.ENDS
***************************************
.SUBCKT pmos_rf_25od D G S B
.ENDS
***************************************
.SUBCKT pmos_rf_25od33_5t D G S B PG
.ENDS
***************************************
.SUBCKT pmos_rf_25od33_nw_5t D G S B PG
.ENDS
***************************************
.SUBCKT pmos_rf_25ud D G S B
.ENDS
***************************************
.SUBCKT pmos_rf_25ud18_5t D G S B PG
.ENDS
***************************************
.SUBCKT pmos_rf_25ud18_nw_5t D G S B PG
.ENDS
***************************************
.SUBCKT pmos_rf_33 D G S B
.ENDS
***************************************
.SUBCKT pmos_rf_33_5t D G S B PG
.ENDS
***************************************
.SUBCKT pmos_rf_33_nw D G S B
.ENDS
***************************************
.SUBCKT pmos_rf_33_nw_5t D G S B PG
.ENDS
***************************************
.SUBCKT pmos_rf_5t D G S B PG
.ENDS
***************************************
.SUBCKT pmos_rf_hvt D G S B
.ENDS
***************************************
.SUBCKT pmos_rf_hvt_5t D G S B PG
.ENDS
***************************************
.SUBCKT pmos_rf_hvt_nw D G S B
.ENDS
***************************************
.SUBCKT pmos_rf_hvt_nw_5t D G S B PG
.ENDS
***************************************
.SUBCKT pmos_rf_lvt D G S B
.ENDS
***************************************
.SUBCKT pmos_rf_lvt_5t D G S B PG
.ENDS
***************************************
.SUBCKT pmos_rf_lvt_nw D G S B
.ENDS
***************************************
.SUBCKT pmos_rf_lvt_nw_5t D G S B PG
.ENDS
***************************************
.SUBCKT pmos_rf_mlvt D G S B
.ENDS
***************************************
.SUBCKT pmos_rf_mlvt_5t D G S B PG
.ENDS
***************************************
.SUBCKT pmos_rf_mlvt_nw D G S B
.ENDS
***************************************
.SUBCKT pmos_rf_mlvt_nw_5t D G S B PG
.ENDS
***************************************
.SUBCKT pmos_rf_nw D G S B
.ENDS
***************************************
.SUBCKT pmos_rf_nw_5t D G S B PG
.ENDS
***************************************
.SUBCKT pmos_rf_rdk D G S B
.ENDS
***************************************
.SUBCKT pmoscap_rf PLUS MINUS BULK
.ENDS
***************************************
.SUBCKT pmoscap_rf18 PLUS MINUS BULK
.ENDS
***************************************
.SUBCKT pmoscap_rf25 PLUS MINUS BULK
.ENDS
***************************************
.SUBCKT probe1 TOP BULK
.ENDS
***************************************
.SUBCKT probe2 TOP BULK
.ENDS
***************************************
.SUBCKT probe3 TOP BULK
.ENDS
***************************************
.SUBCKT probe4 TOP BULK
.ENDS
***************************************
.SUBCKT probe5 TOP BULK
.ENDS
***************************************
.SUBCKT probe6 TOP BULK
.ENDS
***************************************
.SUBCKT probe7 TOP BULK
.ENDS
***************************************
.SUBCKT rfesd_rf1 APAD CPAD DCPAD GNODE
.ENDS
***************************************
.SUBCKT rfesd_rf2 APAD CPAD DCPAD GNODE
.ENDS
***************************************
.SUBCKT rfesd_rf3 APAD CPAD DCPAD GNODE
.ENDS
***************************************
.SUBCKT rfesd_rf4 APAD CPAD DCPAD GNODE
.ENDS
***************************************
.SUBCKT rfesd_rf5 APAD CPAD DCPAD GNODE
.ENDS
***************************************
.SUBCKT rfesd_rf6 APAD CPAD DCPAD GNODE
.ENDS
***************************************
.SUBCKT rfesd_rf7 APAD CPAD DCPAD GNODE
.ENDS
***************************************
.SUBCKT rfesd_rf8 APAD CPAD DCPAD GNODE
.ENDS
***************************************
.SUBCKT rm1 PLUS MINUS
.ENDS
***************************************
.SUBCKT rm10 PLUS MINUS
.ENDS
***************************************
.SUBCKT rm2 PLUS MINUS
.ENDS
***************************************
.SUBCKT rm3 PLUS MINUS
.ENDS
***************************************
.SUBCKT rm4 PLUS MINUS
.ENDS
***************************************
.SUBCKT rm5 PLUS MINUS
.ENDS
***************************************
.SUBCKT rm6 PLUS MINUS
.ENDS
***************************************
.SUBCKT rm7 PLUS MINUS
.ENDS
***************************************
.SUBCKT rm8 PLUS MINUS
.ENDS
***************************************
.SUBCKT rm9 PLUS MINUS
.ENDS
***************************************
.SUBCKT rnodl PLUS MINUS
.ENDS
***************************************
.SUBCKT rnodl_m PLUS MINUS BULK
.ENDS
***************************************
.SUBCKT rnods PLUS MINUS
.ENDS
***************************************
.SUBCKT rnods_m PLUS MINUS BULK
.ENDS
***************************************
.SUBCKT rnodwo PLUS MINUS
.ENDS
***************************************
.SUBCKT rnodwo_m PLUS MINUS BULK
.ENDS
***************************************
.SUBCKT rnpolyl PLUS MINUS
.ENDS
***************************************
.SUBCKT rnpolyl_m PLUS MINUS BULK
.ENDS
***************************************
.SUBCKT rnpolys PLUS MINUS
.ENDS
***************************************
.SUBCKT rnpolys_m PLUS MINUS BULK
.ENDS
***************************************
.SUBCKT rnpolywo PLUS MINUS
.ENDS
***************************************
.SUBCKT rnpolywo_m PLUS MINUS BULK
.ENDS
***************************************
.SUBCKT rnwod PLUS MINUS
.ENDS
***************************************
.SUBCKT rnwod_m PLUS MINUS BULK
.ENDS
***************************************
.SUBCKT rnwsti PLUS MINUS
.ENDS
***************************************
.SUBCKT rnwsti_m PLUS MINUS BULK
.ENDS
***************************************
.SUBCKT rpodl PLUS MINUS
.ENDS
***************************************
.SUBCKT rpodl_m PLUS MINUS BULK
.ENDS
***************************************
.SUBCKT rpods PLUS MINUS
.ENDS
***************************************
.SUBCKT rpods_m PLUS MINUS BULK
.ENDS
***************************************
.SUBCKT rpodwo PLUS MINUS
.ENDS
***************************************
.SUBCKT rpodwo_m PLUS MINUS BULK
.ENDS
***************************************
.SUBCKT rppolyl PLUS MINUS
.ENDS
***************************************
.SUBCKT rppolyl_m PLUS MINUS BULK
.ENDS
***************************************
.SUBCKT rppolyl_rf PLUS MINUS BULK
.ENDS
***************************************
.SUBCKT rppolyl_rf_rdk PLUS MINUS BULK
.ENDS
***************************************
.SUBCKT rppolys PLUS MINUS
.ENDS
***************************************
.SUBCKT rppolys_m PLUS MINUS BULK
.ENDS
***************************************
.SUBCKT rppolys_rf PLUS MINUS BULK
.ENDS
***************************************
.SUBCKT rppolys_rf_rdk PLUS MINUS BULK
.ENDS
***************************************
.SUBCKT rppolywo PLUS MINUS
.ENDS
***************************************
.SUBCKT rppolywo_m PLUS MINUS BULK
.ENDS
***************************************
.SUBCKT rppolywo_rf PLUS MINUS BULK
.ENDS
***************************************
.SUBCKT rppolywo_rf_rdk PLUS MINUS BULK
.ENDS
***************************************
.SUBCKT sbd_rf PLUS MINUS BULK
.ENDS
***************************************
.SUBCKT sbd_rf_nw PLUS MINUS BULK
.ENDS
***************************************
.SUBCKT sline_gscpw_mu PLUS MINUS BULK
.ENDS
***************************************
.SUBCKT sline_ms_mu PLUS MINUS BULK
.ENDS
***************************************
.SUBCKT spiral_std_mu_z PLUS MINUS BULK
.ENDS
***************************************
.SUBCKT spiral_std_mu_z_rdk PLUS MINUS BULK
.ENDS
***************************************
.SUBCKT spiral_sym_ct_mu_z PLUS MINUS BULK CTAP
.ENDS
***************************************
.SUBCKT spiral_sym_ct_mu_z_rdk PLUS MINUS BULK CTAP
.ENDS
***************************************
.SUBCKT spiral_sym_mu_z PLUS MINUS BULK
.ENDS
***************************************
.SUBCKT spiral_sym_mu_z_rdk PLUS MINUS BULK
.ENDS
***************************************
.SUBCKT xjvar PLUS MINUS BULK
.ENDS
***************************************
.SUBCKT xjvar_nw PLUS MINUS BULK
.ENDS
***************************************
.SUBCKT TAPCELLBWP7T
** N=2 EP=0 IP=0 FDC=0
*.CALIBRE ISOLATED NETS: VSS VDD
.ENDS
***************************************
.SUBCKT DFCNQD2BWP7T CP D CDN Q VSS VDD
** N=19 EP=6 IP=0 FDC=30
M0 VSS CP 7 VSS nch L=6e-08 W=1.5e-07 $X=230 $Y=200 $D=4
M1 9 7 VSS VSS nch L=6e-08 W=1.5e-07 $X=520 $Y=345 $D=4
M2 16 7 VSS VSS nch L=6e-08 W=1.6e-07 $X=980 $Y=240 $D=4
M3 8 D 16 VSS nch L=6e-08 W=1.6e-07 $X=1170 $Y=240 $D=4
M4 17 9 8 VSS nch L=6e-08 W=1.5e-07 $X=1505 $Y=350 $D=4
M5 18 10 17 VSS nch L=6e-08 W=1.5e-07 $X=1755 $Y=220 $D=4
M6 VSS CDN 18 VSS nch L=6e-08 W=1.5e-07 $X=1955 $Y=220 $D=4
M7 10 8 VSS VSS nch L=6e-08 W=1.5e-07 $X=2315 $Y=200 $D=4
M8 12 9 10 VSS nch L=6e-08 W=1.5e-07 $X=2660 $Y=350 $D=4
M9 11 7 12 VSS nch L=6e-08 W=1.5e-07 $X=2950 $Y=400 $D=4
M10 VSS 13 11 VSS nch L=6e-08 W=1.5e-07 $X=3500 $Y=210 $D=4
M11 19 CDN VSS VSS nch L=6e-08 W=3e-07 $X=3800 $Y=235 $D=4
M12 13 12 19 VSS nch L=6e-08 W=3e-07 $X=4000 $Y=235 $D=4
M13 Q 13 VSS VSS nch L=6e-08 W=2.8e-07 $X=4455 $Y=220 $D=4
M14 VSS 13 Q VSS nch L=6e-08 W=2.8e-07 $X=4715 $Y=220 $D=4
M15 VDD CP 7 VDD pch L=6e-08 W=1.9e-07 $X=230 $Y=820 $D=103
M16 9 7 VDD VDD pch L=6e-08 W=1.7e-07 $X=470 $Y=820 $D=103
M17 14 9 VDD VDD pch L=6e-08 W=1.6e-07 $X=960 $Y=820 $D=103
M18 8 D 14 VDD pch L=6e-08 W=1.6e-07 $X=1150 $Y=820 $D=103
M19 15 7 8 VDD pch L=6e-08 W=1.5e-07 $X=1470 $Y=900 $D=103
M20 VDD 10 15 VDD pch L=6e-08 W=1.5e-07 $X=1710 $Y=900 $D=103
M21 VDD CDN 15 VDD pch L=6e-08 W=1.5e-07 $X=2200 $Y=1030 $D=103
M22 10 8 VDD VDD pch L=6e-08 W=1.5e-07 $X=2520 $Y=870 $D=103
M23 12 7 10 VDD pch L=6e-08 W=1.5e-07 $X=2875 $Y=870 $D=103
M24 11 9 12 VDD pch L=6e-08 W=1.5e-07 $X=3200 $Y=870 $D=103
M25 VDD 13 11 VDD pch L=6e-08 W=1.5e-07 $X=3460 $Y=870 $D=103
M26 13 CDN VDD VDD pch L=6e-08 W=1.9e-07 $X=3830 $Y=990 $D=103
M27 VDD 12 13 VDD pch L=6e-08 W=3.25e-07 $X=4090 $Y=855 $D=103
M28 Q 13 VDD VDD pch L=6e-08 W=3.45e-07 $X=4455 $Y=855 $D=103
M29 VDD 13 Q VDD pch L=6e-08 W=3.45e-07 $X=4715 $Y=855 $D=103
.ENDS
***************************************
.SUBCKT lfsr4 rst clk data_out[0] VSS VDD data_out[1] data_out[2] data_out[3]
** N=35 EP=8 IP=22 FDC=144
M0 2 rst VSS VSS nch L=6e-08 W=2.05e-07 $X=3435 $Y=2210 $D=4
M1 VSS 4 3 VSS nch L=6e-08 W=3e-07 $X=4015 $Y=2210 $D=4
M2 VSS 3 6 VSS nch L=6e-08 W=1.85e-07 $X=4595 $Y=2230 $D=4
M3 30 3 VSS VSS nch L=6e-08 W=1.5e-07 $X=4865 $Y=2410 $D=4
M4 10 3 30 VSS nch L=6e-08 W=1.5e-07 $X=5125 $Y=2230 $D=4
M5 31 6 10 VSS nch L=6e-08 W=1.5e-07 $X=5385 $Y=2230 $D=4
M6 VSS 7 31 VSS nch L=6e-08 W=3.15e-07 $X=5610 $Y=2230 $D=4
M7 VSS clk 8 VSS nch L=6e-08 W=1.5e-07 $X=6155 $Y=2395 $D=4
M8 9 8 VSS VSS nch L=6e-08 W=1.5e-07 $X=6395 $Y=2395 $D=4
M9 12 8 10 VSS nch L=6e-08 W=1.5e-07 $X=6880 $Y=2210 $D=4
M10 32 9 12 VSS nch L=6e-08 W=1.5e-07 $X=7155 $Y=2360 $D=4
M11 VSS 13 32 VSS nch L=6e-08 W=1.5e-07 $X=7430 $Y=2390 $D=4
M12 33 12 VSS VSS nch L=6e-08 W=1.5e-07 $X=7810 $Y=2390 $D=4
M13 13 2 33 VSS nch L=6e-08 W=1.5e-07 $X=8010 $Y=2390 $D=4
M14 15 9 13 VSS nch L=6e-08 W=1.5e-07 $X=8270 $Y=2390 $D=4
M15 14 8 15 VSS nch L=6e-08 W=1.5e-07 $X=8530 $Y=2390 $D=4
M16 34 2 14 VSS nch L=6e-08 W=1.5e-07 $X=9070 $Y=2390 $D=4
M17 VSS 16 34 VSS nch L=6e-08 W=1.5e-07 $X=9270 $Y=2390 $D=4
M18 16 15 VSS VSS nch L=6e-08 W=3.1e-07 $X=9610 $Y=2230 $D=4
M19 data_out[0] 16 VSS VSS nch L=6e-08 W=2.8e-07 $X=10185 $Y=2230 $D=4
M20 VSS 16 data_out[0] VSS nch L=6e-08 W=2.8e-07 $X=10485 $Y=2230 $D=4
M21 VSS data_out[2] 23 VSS nch L=6e-08 W=1.5e-07 $X=25985 $Y=2360 $D=4
M22 35 24 VSS VSS nch L=6e-08 W=1.5e-07 $X=26315 $Y=2390 $D=4
M23 25 data_out[2] 35 VSS nch L=6e-08 W=1.5e-07 $X=26605 $Y=2210 $D=4
M24 24 23 25 VSS nch L=6e-08 W=1.5e-07 $X=26865 $Y=2210 $D=4
M25 VSS data_out[3] 24 VSS nch L=6e-08 W=1.5e-07 $X=27155 $Y=2430 $D=4
M26 7 25 VSS VSS nch L=6e-08 W=1.5e-07 $X=27485 $Y=2360 $D=4
M27 2 rst VDD VDD pch L=6e-08 W=3.8e-07 $X=3435 $Y=2830 $D=103
M28 4 4 VDD VDD pch L=6e-08 W=3.8e-07 $X=4015 $Y=2830 $D=103
M29 VDD 3 6 VDD pch L=6e-08 W=1.9e-07 $X=4595 $Y=3020 $D=103
M30 26 3 VDD VDD pch L=6e-08 W=1.5e-07 $X=4915 $Y=2880 $D=103
M31 11 6 26 VDD pch L=6e-08 W=1.5e-07 $X=5115 $Y=2880 $D=103
M32 27 3 11 VDD pch L=6e-08 W=1.75e-07 $X=5405 $Y=3015 $D=103
M33 VDD 7 27 VDD pch L=6e-08 W=3.25e-07 $X=5650 $Y=2865 $D=103
M34 VDD clk 8 VDD pch L=6e-08 W=1.9e-07 $X=6155 $Y=2865 $D=103
M35 9 8 VDD VDD pch L=6e-08 W=1.9e-07 $X=6410 $Y=2865 $D=103
M36 12 9 11 VDD pch L=6e-08 W=1.6e-07 $X=6915 $Y=2870 $D=103
M37 28 8 12 VDD pch L=6e-08 W=1.5e-07 $X=7200 $Y=2910 $D=103
M38 VDD 13 28 VDD pch L=6e-08 W=1.5e-07 $X=7475 $Y=2860 $D=103
M39 13 12 VDD VDD pch L=6e-08 W=1.5e-07 $X=7755 $Y=2860 $D=103
M40 VDD 2 13 VDD pch L=6e-08 W=1.5e-07 $X=8015 $Y=2860 $D=103
M41 15 8 13 VDD pch L=6e-08 W=1.5e-07 $X=8490 $Y=2865 $D=103
M42 14 9 15 VDD pch L=6e-08 W=1.5e-07 $X=8750 $Y=2865 $D=103
M43 VDD 2 14 VDD pch L=6e-08 W=1.5e-07 $X=9010 $Y=2865 $D=103
M44 14 16 VDD VDD pch L=6e-08 W=1.6e-07 $X=9250 $Y=2865 $D=103
M45 16 15 VDD VDD pch L=6e-08 W=3.25e-07 $X=9725 $Y=2865 $D=103
M46 data_out[0] 16 VDD VDD pch L=6e-08 W=3.8e-07 $X=10225 $Y=2830 $D=103
M47 VDD 16 data_out[0] VDD pch L=6e-08 W=3.8e-07 $X=10485 $Y=2830 $D=103
M48 VDD data_out[2] 23 VDD pch L=6e-08 W=1.9e-07 $X=25985 $Y=3020 $D=103
M49 29 24 VDD VDD pch L=6e-08 W=1.5e-07 $X=26285 $Y=2860 $D=103
M50 25 23 29 VDD pch L=6e-08 W=1.5e-07 $X=26495 $Y=2860 $D=103
M51 24 data_out[2] 25 VDD pch L=6e-08 W=1.9e-07 $X=26765 $Y=3020 $D=103
M52 VDD data_out[3] 24 VDD pch L=6e-08 W=1.9e-07 $X=27075 $Y=3020 $D=103
M53 7 25 VDD VDD pch L=6e-08 W=1.9e-07 $X=27485 $Y=3020 $D=103
X56 clk data_out[0] 2 data_out[1] VSS VDD DFCNQD2BWP7T $T=10770 2010 0 0 $X=10535 $Y=1905
X57 clk data_out[1] 2 data_out[2] VSS VDD DFCNQD2BWP7T $T=15770 2010 0 0 $X=15535 $Y=1905
X58 clk data_out[2] 2 data_out[3] VSS VDD DFCNQD2BWP7T $T=20770 2010 0 0 $X=20535 $Y=1905
.ENDS
***************************************
